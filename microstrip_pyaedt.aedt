# Ansys Electronics Desktop project, version 2021.2
materials:
  vacuum: permittivity=1
  FR4_epoxy: permittivity=4.4 dielectric_loss_tangent=0.02
  copper: permeability=0.999991 conductivity=58000000
surface materials:
  Steel-oxidised-surface

design HFSS_UDJ (HFSS, DrivenModal, model units mm)
options: Calculate_Lossy_Dielectrics
variables:
  w_line = 2.7mm
  t_line = 0.035mm
  w_sub = 30mm
  l_sub = 60mm
  t_sub = 1.5mm
geometry:
  substrate [fr4_epoxy] = box(corner=(-w_sub/2, 0mm, -t_sub), size=(w_sub, l_sub, t_sub))
  line [copper] = box(corner=(-w_line/2, 0mm, 0mm), size=(w_line, l_sub, t_line))
  backside [copper] = box(corner=(-w_sub/2, 0mm, -t_sub - t_line), size=(w_sub, l_sub, t_line))
  line_ObjectFromEdge1 [copper] = object_from(line.edge(6 of 12))
  line_ObjectFromEdge2 = object_from(line.edge(6 of 12))
  line_ObjectFromEdge2.move(0mm, 0mm, -1.5mm)
  line_ObjectFromEdge1.connect(line_ObjectFromEdge2)
  line_ObjectFromEdge3 [copper] = object_from(line.edge(8 of 12))
  line_ObjectFromEdge4 = object_from(line.edge(8 of 12))
  line_ObjectFromEdge4.move(0mm, 0mm, -1.5mm)
  line_ObjectFromEdge3.connect(line_ObjectFromEdge4)
  Region [vacuum] = region(percentage_offset=20 on all sides)
boundaries and excitations:
  Port1: Lumped Port Objects=line_ObjectFromEdge1 Modes{Mode1{IntLine{middle of line_ObjectFromEdge1.edge(at (0, 0, 0)) -> middle of line_ObjectFromEdge1.edge(at (0, 0, -1.5))} CharImp=Zpi RenormImp=50ohm}} Impedance=50ohm
  Port2: Lumped Port Objects=line_ObjectFromEdge3 Modes{Mode1{IntLine{middle of line_ObjectFromEdge3.edge(at (0, 60, 0)) -> middle of line_ObjectFromEdge3.edge(at (0, 60, -1.5))} CharImp=Zpi RenormImp=50ohm}} Impedance=50ohm
setups:
  my_hfss_run: HfssDriven Frequency=5GHz MaxDeltaS=0.02 MaximumPasses=10 MinimumPasses=1 MinimumConvergedPasses=1 PercentRefinement=30 BasisOrder=1 PortAccuracy=2 UseABCOnPort
    sweep LinearCountSweep: 0.01GHz to 20GHz, 101 points; Type=Interpolating InterpTolerance=0.5 InterpMaxSolns=250 InterpUsePortImped=false PassivityErrorTolerance=0.0001
source amplitudes:
  Port1:1: 1W 0deg
  Port2:1: 0W 0deg
field plots:
  Mesh1: MeshPlots over line.face(all 6) on my_hfss_run : LastAdaptive at Freq=5GHz Phase=0deg
  Mesh2: MeshPlots in substrate on my_hfss_run : LastAdaptive at Freq=5GHz Phase=0deg
reports:
  S Parameter Plot 1: dB(S(Port1,Port1)), dB(S(Port2,Port1)), dB(S(Port1,Port2)), dB(S(Port2,Port2)) vs Freq on my_hfss_run : LinearCountSweep
